ADE simulation setup
Run mode: Single Run, Sweeps and Corners
Tests:
  Project:1-bit-adder-test:1: Project/1-bit-adder-test/schematic, simulator spectre
